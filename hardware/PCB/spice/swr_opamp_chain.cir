* Raw SW-112 forward detector: approximate 1M source, 100M bias, ideal buffer + ADC filter
* Omits detector nonlinearity, input/clamp leakage, RF pickup, and power-off behavior.
.param VSAT_H=11.95 VSAT_L=0.05
VIN DETECTOR 0 DC 0
RSOURCE DETECTOR FWD_IN 1Meg
R4 FWD_IN 0 100Meg
R14 FWD_IN FWD_BUF 1k
Bbuf IN1 0 V = min(max(V(FWD_BUF), VSAT_L), VSAT_H)
R10 IN1 FWD_OUT 3.3k
R13 FWD_OUT 0 1k
C12 FWD_OUT 0 100n
.control
dc VIN 0 13 0.5
wrdata swr_sweep.txt v(FWD_IN) v(IN1) v(FWD_OUT)
quit
.endc
.end
