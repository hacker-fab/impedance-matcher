* Monte Carlo tolerance analysis - SWR ADC divider R10/R13
* Worst case: op-amp buffer saturated at 11.95V (its 12V rail)
* Divider R10=2.7k (top), R13=1k (bottom), nominal ratio = 1/(1+2.7) = 0.27027
* Gaussian resistor tolerance, 200 runs, seed 42
* Pessimistic case: 1% treated as 1 sigma (widest spread)

.control
set rndseed=42
let n = 200
let i = 0
let vmax = 0
let vmin = 100
let vsum = 0
let vin = 11.95
dowhile i < n
  * 1% as 1-sigma (pessimistic spread)
  let r10 = 2700 * (1 + 0.01 * sgauss(0))
  let r13 = 1000 * (1 + 0.01 * sgauss(0))
  let vadc = vin * r13 / (r10 + r13)
  if vadc > vmax
    let vmax = vadc
  end
  if vadc < vmin
    let vmin = vadc
  end
  let vsum = vsum + vadc
  let i = i + 1
end
let vmean = vsum / n
echo "MC_RESULTS runs=$&n vin=$&vin vmean=$&vmean vmin=$&vmin vmax=$&vmax fullscale=3.3" > mc_swr_divider.out
quit
.endc
.end
